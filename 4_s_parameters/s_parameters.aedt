# Ansys Electronics Desktop project, version 2025.2
materials:
  copper: permeability=0.999991 conductivity=58000000

design Circuit1 (Circuit)
options: SParamCircuitDef IntegrationMethod=FFT
components:
  A4 = MS_TRL(P=50000mil W=26.5mil)
  port Port1 rz=50ohm iz=0ohm EnableNoise=false noisetemp=16.85cel
  port Port2 rz=50ohm iz=0ohm EnableNoise=false noisetemp=16.85cel
nets:
  Port1: A4.0
  Port2: A4.1
setups:
  LinearFrequency: LinearFrequencyData(false, 0.1, false, "", false) SweepDefinition{Variable=Freq Data="LINC 0.1GHz 25GHz 1000"}
reports:
  S Parameter Plot1: dB(S(Port1,Port1)) vs Freq on LinearFrequency : LinearFrequency
  S Parameter Plot3: dB(S(Port1,Port2)), dB(S(Port1,Port2)) vs Freq on LinearFrequency : LinearFrequency
