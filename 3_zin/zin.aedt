# Ansys Electronics Desktop project, version 2019.1

design Circuit1 (Circuit)
options: SParamCircuitDef IntegrationMethod=FFT
components:
  R2 = RES_(R=200)
  A8 = NXCOAXK(P=1000mm C1=0.4)
  R1 = RES_(R=50)
  V24 = V_SIN(ACMAG=1V VA=1V FREQ=10)
  Z26 = IPROBE(Name=driver)
nets:
  0: R2.0, V24.1
  load: A8.1, R2.1
  net_5: R1.1, V24.0
  net_6: A8.0, Z26.1
  net_7: R1.0, Z26.0
setups:
  LinearFrequency: LinearFrequencyData(false, 0.1, false, "", false) SweepDefinition{Variable=F Data="DEC 0.001GHz 100GHz 10"}
reports:
  Voltage Plot 1: dB(V(load)) vs F on LinearFrequency : LinearFrequency
  Current Plot 1: arg(I(driver)) vs F on LinearFrequency : LinearFrequency
