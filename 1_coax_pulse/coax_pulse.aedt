# Ansys Electronics Desktop project, version 2019.1

design Circuit1 (Circuit)
options: SParamCircuitDef IntegrationMethod=FFT
components:
  R2 = RES_(R=80)
  A8 = NXCOAXK(P=1000mm C1=0.01)
  V9 = V_PULSE(V2=3.3V TD=0.1ns TR=1000ps TF=1000ps)
  A1 = NXCOAXK(P=1000mm C1=0.01)
  R1 = RES_(R=10)
nets:
  0: V9.1, R2.0
  driver: R1.0, A8.0
  load: A1.1, R2.1
  mid: A1.0, A8.1
  net_5: R1.1, V9.0
setups:
  NexximTransient1: TransientData(1ps, 40ns) TransientNoiseData(false, "", "", 0, 1, 0, false, 1) TransientOtherData(strict)
reports:
  Transient Voltage Plot 1: V(driver), V(load), V(mid) vs Time on NexximTransient1 : NexximTransient1
