# Ansys Electronics Desktop project, version 2025.2
materials:
  copper: permeability=0.999991 conductivity=58000000

design Circuit1 (Circuit)
options: SParamCircuitDef IntegrationMethod=FFT
components:
  A4 = MS_TRL(P=20000mil W=26.5mil)
  A5 = EYESOURCE(UIorBPSValue=2e-10s trise=50ps tfall=50ps)
  R7 = RES_()
  A8 = EYEPROBE(source_name=AEYESOURCE5)
nets:
  0: R7.0
  net_1: A4.0, A5.0
  net_2: A4.1, R7.1, A8.0
setups:
  QuickEyeAnalysis: QuickEyeAnalysis(false, 1e-9, false, 0, "", true, true, 32)
reports:
  QuickEye Voltage Plot1: AEYEPROBE(required) vs Time on QuickEyeAnalysis : QuickEyeAnalysis
