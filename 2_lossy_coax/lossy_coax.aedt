# Ansys Electronics Desktop project, version 2019.1

design Circuit1 (Circuit)
options: SParamCircuitDef IntegrationMethod=FFT
components:
  R2 = RES_(R=50)
  A8 = NXCOAXK(P=1000mm C1=0.4)
  A1 = NXCOAXK(P=1000mm C1=0.4 K=4)
  R1 = RES_(R=50)
  V24 = V_SIN(ACMAG=0V VA=1V FREQ=10GHz)
nets:
  0: R2.0, V24.1
  driver: A8.0, R1.0
  load: A1.1, R2.1
  mid: A8.1, A1.0
  net_5: R1.1, V24.0
setups:
  NexximTransient1: TransientData(1ps, 40ns) TransientNoiseData(false, "", "", 0, 1, 0, false, 1) TransientOtherData(strict)
reports:
  Transient Voltage Plot 1: V(driver), V(load), V(mid) vs Time on NexximTransient1 : NexximTransient1
